************************************************************************
*
* Copyright 2024 IHP PDK Authors
*
* Licensed under the Apache License, Version 2.0 (the "License");
* you may not use this file except in compliance with the License.
* You may obtain a copy of the License at
*
*    https://www.apache.org/licenses/LICENSE-2.0
*
* Unless required by applicable law or agreed to in writing, software
* distributed under the License is distributed on an "AS IS" BASIS,
* WITHOUT WARRANTIES OR CONDITIONS OF ANY KIND, either express or implied.
* See the License for the specific language governing permissions and
* limitations under the License.
*
************************************************************************

* Library name: sg13cmos5l_io
* Cell name: sg13cmos5l_DCNDiode
* View name: schematic
.subckt sg13cmos5l_DCNDiode anode cathode_1 cathode_2 guard
XD1 anode cathode_1 dantenna w=27.78u l=1.26u m=1
XD0 anode cathode_2 dantenna w=27.78u l=1.26u m=1
.ends
* End of subcircuit definition.

* Library name: sg13cmos5l_io
* Cell name: sg13cmos5l_DCPDiode
* View name: schematic
.subckt sg13cmos5l_DCPDiode anode_1 anode_2 cathode guard
XD1 anode_1 cathode dpantenna w=27.78u l=1.26u m=1
XD0 anode_2 cathode dpantenna w=27.78u l=1.26u m=1
.ends
* End of subcircuit definition.

* Library name: sg13cmos5l_io
* Cell name: sg13cmos5l_IOPadIOVss
* View name: schematic
.subckt sg13cmos5l_IOPadIOVss vdd vss iovdd iovss
XI3 iovss iovss iovss iovdd sg13cmos5l_DCNDiode
XI2 iovss iovss iovdd iovss sg13cmos5l_DCPDiode
.ends
* End of subcircuit definition.

* Library name: sg13cmos5l_io
* Cell name: sg13cmos5l_Clamp_N43N43D4R
* View name: schematic
.subckt sg13cmos5l_Clamp_N43N43D4R gate iovss pad
XN0 pad gate iovss iovss sg13_hv_nmos w=4.4u l=600.0n ng=1 ad=1.496e-12 as=1.496e-12 pd=9.48e-06 ps=9.48e-06 m=172
XD0 iovss gate dantenna l=480n w=480n m=1
.ends
* End of subcircuit definition.

* Library name: sg13cmos5l_io
* Cell name: sg13cmos5l_RCClampResistor
* View name: schematic
.subckt sg13cmos5l_RCClampResistor pin1 pin2 sub
XR15 net15 net16 sub rppd l=20u w=1u
XR20 net20 net21 sub rppd l=20u w=1u
XR23 net23 net24 sub rppd l=20u w=1u
XR17 net17 net18 sub rppd l=20u w=1u
XR16 net16 net17 sub rppd l=20u w=1u
XR25 net25 pin2 sub rppd l=20u w=1u
XR22 net22 net23 sub rppd l=20u w=1u
XR19 net19 net20 sub rppd l=20u w=1u
XR24 net24 net25 sub rppd l=20u w=1u
XR21 net21 net22 sub rppd l=20u w=1u
XR18 net18 net19 sub rppd l=20u w=1u
XR5 net5 net6 sub rppd l=20u w=1u
XR8 net8 net9 sub rppd l=20u w=1u
XR11 net11 net12 sub rppd l=20u w=1u
XR14 net14 net15 sub rppd l=20u w=1u
XR2 net2 net3 sub rppd l=20u w=1u
XR1 net1 net2 sub rppd l=20u w=1u
XR13 net13 net14 sub rppd l=20u w=1u
XR10 net10 net11 sub rppd l=20u w=1u
XR7 net7 net8 sub rppd l=20u w=1u
XR4 net4 net5 sub rppd l=20u w=1u
XR12 net12 net13 sub rppd l=20u w=1u
XR9 net9 net10 sub rppd l=20u w=1u
XR6 net6 net7 sub rppd l=20u w=1u
XR3 net3 net4 sub rppd l=20u w=1u
XR0 pin1 net1 sub rppd l=20u w=1u
.ends
* End of subcircuit definition.

* Library name: sg13cmos5l_io
* Cell name: sg13cmos5l_RCClampInverter
* View name: schematic
.subckt sg13cmos5l_RCClampInverter out in iovss supply
XN1 iovss in iovss iovss sg13_hv_nmos w=63.000u l=9.5u ng=7 ad=1.332e-11 as=1.332e-11 pd=7.496e-05 ps=7.496e-05 m=1
XN3 out in iovss iovss sg13_hv_nmos w=54.000u l=500.0n ng=6 ad=1.026e-11 as=1.296e-11 pd=5.628e-05 ps=7.488e-05 m=1
XN0 iovss in iovss iovss sg13_hv_nmos w=63.000u l=9.5u ng=7 ad=1.332e-11 as=1.332e-11 pd=7.496e-05 ps=7.496e-05 m=1
XN2 out in iovss iovss sg13_hv_nmos w=54.000u l=500.0n ng=6 ad=1.026e-11 as=1.296e-11 pd=5.628e-05 ps=7.488e-05 m=1
XP0 out in supply supply sg13_hv_pmos w=350.000u l=500.0n ng=50 ad=6.65e-11 as=6.86e-11 pd=0.000369 ps=0.0003836 m=1
.ends
* End of subcircuit definition.

* Library name: sg13cmos5l_io
* Cell name: sg13cmos5l_IOPadVdd
* View name: schematic
.subckt sg13cmos5l_IOPadVdd vdd vss iovdd iovss
XI1 net3 iovss vdd sg13cmos5l_Clamp_N43N43D4R
XI4 vdd net1 iovss sg13cmos5l_RCClampResistor
XI3 net3 net1 iovss vdd sg13cmos5l_RCClampInverter
.ends
* End of subcircuit definition.

* Library name: sg13cmos5l_io
* Cell name: sg13cmos5l_IOPadIOVdd
* View name: schematic
.subckt sg13cmos5l_IOPadIOVdd vdd vss iovdd iovss
XI1 net4 iovss iovdd sg13cmos5l_Clamp_N43N43D4R
XI3 iovdd net1 iovss sg13cmos5l_RCClampResistor
XI2 net4 net1 iovss iovdd sg13cmos5l_RCClampInverter
.ends
* End of subcircuit definition.

* Library name: sg13cmos5l_io
* Cell name: sg13cmos5l_IOPadVss
* View name: schematic
.subckt sg13cmos5l_IOPadVss vdd vss iovdd iovss
XI1 iovss vss vss iovdd sg13cmos5l_DCNDiode
XI2 vss vss iovdd iovss sg13cmos5l_DCPDiode
.ends
* End of subcircuit definition.

* Library name: sg13cmos5l_io
* Cell name: sg13cmos5l_Filler2000
* View name: schematic
.subckt sg13cmos5l_Filler2000 vdd vss iovdd iovss
.ends
* End of subcircuit definition.

* Library name: sg13cmos5l_io
* Cell name: sg13cmos5l_io_inv_x1
* View name: schematic
.subckt sg13cmos5l_io_inv_x1 nq i vdd vss
XN0 nq i vss vss sg13_lv_nmos w=3.93u l=130.00n ng=1 ad=1.336e-12 as=1.336e-12 pd=8.54e-06 ps=8.54e-06 m=1
XP0 nq i vdd vdd sg13_lv_pmos w=4.41u l=130.00n ng=1 ad=1.499e-12 as=1.499e-12 pd=9.5e-06 ps=9.5e-06 m=1
.ends
* End of subcircuit definition.

* Library name: sg13cmos5l_io
* Cell name: sg13cmos5l_LevelUp
* View name: schematic
.subckt sg13cmos5l_LevelUp o i iovdd vdd vss
XN1 net2 i vss vss sg13_lv_nmos w=2.75u l=130.00n ng=1 ad=9.35e-13 as=9.35e-13 pd=6.18e-06 ps=6.18e-06 m=1
XP3 net2 i vdd vdd sg13_lv_pmos w=4.75u l=130.00n ng=1 ad=1.615e-12 as=1.615e-12 pd=1.018e-05 ps=1.018e-05 m=1
XN0 o net4 vss vss sg13_hv_nmos w=1.9u l=450.00n ng=1 ad=0.0 as=0.0 pd=0.0 ps=0.0 m=1
XN3 net4 i vss vss sg13_hv_nmos w=1.9u l=450.00n ng=1 ad=0.0 as=0.0 pd=0.0 ps=0.0 m=1
XN2 net3 net2 vss vss sg13_hv_nmos w=1.9u l=450.00n ng=1 ad=0.0 as=0.0 pd=0.0 ps=0.0 m=1
XP0 o net4 iovdd iovdd sg13_hv_pmos w=3.9u l=450.00n ng=1 ad=1.326e-12 as=1.326e-12 pd=8.48e-06 ps=8.48e-06 m=1
XP1 net3 net4 iovdd iovdd sg13_hv_pmos w=300.0n l=450.00n ng=1 ad=1.02e-13 as=1.02e-13 pd=1.28e-06 ps=1.28e-06 m=1
XP2 net4 net3 iovdd iovdd sg13_hv_pmos w=300.0n l=450.00n ng=1 ad=0.0 as=0.0 pd=0.0 ps=0.0 m=1
.ends
* End of subcircuit definition.

* Library name: sg13cmos5l_io
* Cell name: sg13cmos5l_io_nor2_x1
* View name: schematic
.subckt sg13cmos5l_io_nor2_x1 nq i0 i1 vdd vss
XN0 nq i0 vss vss sg13_lv_nmos w=3.93u l=130.00n ng=1 ad=1.336e-12 as=1.336e-12 pd=8.54e-06 ps=8.54e-06 m=1
XN1 nq i1 vss vss sg13_lv_nmos w=3.93u l=130.00n ng=1 ad=1.336e-12 as=1.336e-12 pd=8.54e-06 ps=8.54e-06 m=1
XP0 net1 i0 vdd vdd sg13_lv_pmos w=4.41u l=130.00n ng=1 ad=1.499e-12 as=1.499e-12 pd=9.5e-06 ps=9.5e-06 m=1
XP1 nq i1 net1 vdd sg13_lv_pmos w=4.41u l=130.00n ng=1 ad=1.499e-12 as=1.499e-12 pd=9.5e-06 ps=9.5e-06 m=1
.ends
* End of subcircuit definition.

* Library name: sg13cmos5l_io
* Cell name: sg13cmos5l_io_tie
* View name: schematic
.subckt sg13cmos5l_io_tie vdd vss
.ends
* End of subcircuit definition.

* Library name: sg13cmos5l_io
* Cell name: sg13cmos5l_io_nand2_x1
* View name: schematic
.subckt sg13cmos5l_io_nand2_x1 nq i0 i1 vdd vss
XP1 nq i1 vdd vdd sg13_lv_pmos w=4.41u l=130.00n ng=1 ad=1.499e-12 as=1.499e-12 pd=9.5e-06 ps=9.5e-06 m=1
XP0 nq i0 vdd vdd sg13_lv_pmos w=4.41u l=130.00n ng=1 ad=1.499e-12 as=1.499e-12 pd=9.5e-06 ps=9.5e-06 m=1
XN1 net1 i0 vss vss sg13_lv_nmos w=3.93u l=130.00n ng=1 ad=1.336e-12 as=1.336e-12 pd=8.54e-06 ps=8.54e-06 m=1
XN0 nq i1 net1 vss sg13_lv_nmos w=3.93u l=130.00n ng=1 ad=1.336e-12 as=1.336e-12 pd=8.54e-06 ps=8.54e-06 m=1
.ends
* End of subcircuit definition.

* Library name: sg13cmos5l_io
* Cell name: sg13cmos5l_GateDecode
* View name: schematic
.subckt sg13cmos5l_GateDecode ngate pgate core en iovdd vdd vss
XI1 net3 en vdd vss sg13cmos5l_io_inv_x1
XI4 ngate net4 iovdd vdd vss sg13cmos5l_LevelUp
XI2 pgate net2 iovdd vdd vss sg13cmos5l_LevelUp
XI3 net4 core net3 vdd vss sg13cmos5l_io_nor2_x1
XI0 vdd vss sg13cmos5l_io_tie
XI5 net2 core en vdd vss sg13cmos5l_io_nand2_x1
.ends
* End of subcircuit definition.

* Library name: sg13cmos5l_io
* Cell name: sg13cmos5l_Clamp_N2N2D
* View name: schematic
.subckt sg13cmos5l_Clamp_N2N2D gate iovss pad
XN1 pad gate iovss iovss sg13_hv_nmos w=8.8u l=600.0n ng=2 ad=1.672e-12 as=2.992e-12 pd=9.56e-06 ps=1.896e-05 m=1
XD0 iovss gate dantenna l=780.00n w=780.00n m=1
.ends
* End of subcircuit definition.

* Library name: sg13cmos5l_io
* Cell name: sg13cmos5l_Clamp_P2N2D
* View name: schematic
.subckt sg13cmos5l_Clamp_P2N2D gate iovdd iovss pad
XD0 gate iovdd dpantenna l=480n w=480n m=1
XP1 pad gate iovdd iovdd sg13_hv_pmos w=13.32u l=600.0n ng=2 ad=2.531e-12 as=4.529e-12 pd=1.408e-05 ps=2.8e-05 m=1
XP0 pad gate iovdd iovdd sg13_hv_pmos w=13.32u l=600.0n ng=2 ad=2.531e-12 as=4.529e-12 pd=1.408e-05 ps=2.8e-05 m=1
.ends
* End of subcircuit definition.

* Library name: sg13cmos5l_io
* Cell name: sg13cmos5l_SecondaryProtection
* View name: schematic
.subckt sg13cmos5l_SecondaryProtection core minus pad plus
XR0 pad core minus rppd l=2u w=1u
XD1 minus core dantenna l=3.1u w=640n m=1
XD0 core plus dpantenna w=4.98u l=640n m=1
.ends
* End of subcircuit definition.

* Library name: sg13cmos5l_io
* Cell name: sg13cmos5l_LevelDown
* View name: schematic
.subckt sg13cmos5l_LevelDown core pad iovdd vss vdd
XP0 vdd vdd vdd vdd sg13_hv_pmos w=4.65u l=450.00n ng=1 ad=1.581e-12 as=1.581e-12 pd=9.98e-06 ps=9.98e-06 m=1
XP2 net4 net7 iovdd iovdd sg13_hv_pmos w=4.6u l=450.00n ng=2 ad=8.74e-13 as=1.564e-12 pd=5.36e-06 ps=1.056e-05 m=1
XP3 net7 net1 iovdd iovdd sg13_hv_pmos w=4.6u l=450.00n ng=2 ad=8.74e-13 as=1.564e-12 pd=5.36e-06 ps=1.056e-05 m=1
XN3 net4 net7 vss vss sg13_hv_nmos w=1.3u l=450.00n ng=1 ad=4.42e-13 as=4.42e-13 pd=3.28e-06 ps=3.28e-06 m=1
XN4 net7 net1 vss vss sg13_hv_nmos w=1.3u l=450.00n ng=1 ad=4.42e-13 as=4.42e-13 pd=3.28e-06 ps=3.28e-06 m=1
XN2 net2 net4 vss vss sg13_hv_nmos w=2.65u l=450.00n ng=1 ad=9.01e-13 as=9.01e-13 pd=5.98e-06 ps=5.98e-06 m=1
XN0 vdd net7 net2 vss sg13_hv_nmos w=2.65u l=450.00n ng=1 ad=9.01e-13 as=9.01e-13 pd=5.98e-06 ps=5.98e-06 m=1
XN1 core net2 vss vss sg13_lv_nmos w=2.75u l=130.00n ng=1 ad=9.35e-13 as=9.35e-13 pd=6.18e-06 ps=6.18e-06 m=1
XP1 core net2 vdd vdd sg13_lv_pmos w=4.75u l=130.00n ng=1 ad=1.615e-12 as=1.615e-12 pd=1.018e-05 ps=1.018e-05 m=1
XI0 net1 vss pad iovdd sg13cmos5l_SecondaryProtection
.ends
* End of subcircuit definition.

* Library name: sg13cmos5l_io
* Cell name: sg13cmos5l_IOPadInOut4mA
* View name: schematic
.subckt sg13cmos5l_IOPadInOut4mA pad c2p p2c c2p_en vdd vss iovdd iovss
XI1 pad pad iovdd iovss sg13cmos5l_DCPDiode
XI2 net2 net1 c2p c2p_en iovdd vdd vss sg13cmos5l_GateDecode
XI3 net2 iovss pad sg13cmos5l_Clamp_N2N2D
XI0 net1 iovdd iovss pad sg13cmos5l_Clamp_P2N2D
XI4 p2c pad iovdd iovss vdd sg13cmos5l_LevelDown
XI5 iovss pad pad iovdd sg13cmos5l_DCNDiode
.ends
* End of subcircuit definition.

* Library name: sg13cmos5l_io
* Cell name: sg13cmos5l_Clamp_P15N15D
* View name: schematic
.subckt sg13cmos5l_Clamp_P15N15D gate iovdd iovss pad
XD0 gate iovdd dpantenna l=780.00n w=780.00n m=1
XP1 pad gate iovdd iovdd sg13_hv_pmos w=99.9u l=600.0n ng=15 ad=1.998e-11 as=1.998e-11 pd=0.0001126 ps=0.0001126 m=1
XP0 pad gate iovdd iovdd sg13_hv_pmos w=99.9u l=600.0n ng=15 ad=1.998e-11 as=1.998e-11 pd=0.0001126 ps=0.0001126 m=1
.ends
* End of subcircuit definition.

* Library name: sg13cmos5l_io
* Cell name: sg13cmos5l_Clamp_N15N15D
* View name: schematic
.subckt sg13cmos5l_Clamp_N15N15D gate iovss pad
XN0 pad gate iovss iovss sg13_hv_nmos w=66.000u l=600.0n ng=15 ad=1.32e-11 as=1.32e-11 pd=7.64e-05 ps=7.64e-05 m=1
XD0 iovss gate dantenna l=780.00n w=780.00n m=1
.ends
* End of subcircuit definition.

* Library name: sg13cmos5l_io
* Cell name: sg13cmos5l_IOPadInOut30mA
* View name: schematic
.subckt sg13cmos5l_IOPadInOut30mA pad c2p p2c c2p_en vdd vss iovdd iovss
XI4 p2c pad iovdd iovss vdd sg13cmos5l_LevelDown
XI1 pad pad iovdd iovss sg13cmos5l_DCPDiode
XI0 net1 iovdd iovss pad sg13cmos5l_Clamp_P15N15D
XI5 iovss pad pad iovdd sg13cmos5l_DCNDiode
XI3 net2 iovss pad sg13cmos5l_Clamp_N15N15D
XI2 net2 net1 c2p c2p_en iovdd vdd vss sg13cmos5l_GateDecode
.ends
* End of subcircuit definition.

* Library name: sg13cmos5l_io
* Cell name: sg13cmos5l_LevelUpInv
* View name: schematic
.subckt sg13cmos5l_LevelUpInv o i iovdd vdd vss
XN1 net2 i vss vss sg13_lv_nmos w=2.75u l=130.00n ng=1 ad=9.35e-13 as=9.35e-13 pd=6.18e-06 ps=6.18e-06 m=1
XP3 net2 i vdd vdd sg13_lv_pmos w=4.75u l=130.00n ng=1 ad=1.615e-12 as=1.615e-12 pd=1.018e-05 ps=1.018e-05 m=1
XN0 o net4 vss vss sg13_hv_nmos w=1.9u l=450.00n ng=1 ad=0.0 as=0.0 pd=0.0 ps=0.0 m=1
XN3 net4 net2 vss vss sg13_hv_nmos w=1.9u l=450.00n ng=1 ad=0.0 as=0.0 pd=0.0 ps=0.0 m=1
XN2 net3 i vss vss sg13_hv_nmos w=1.9u l=450.00n ng=1 ad=0.0 as=0.0 pd=0.0 ps=0.0 m=1
XP0 o net4 iovdd iovdd sg13_hv_pmos w=3.9u l=450.00n ng=1 ad=1.326e-12 as=1.326e-12 pd=8.48e-06 ps=8.48e-06 m=1
XP1 net3 net4 iovdd iovdd sg13_hv_pmos w=300.0n l=450.00n ng=1 ad=1.02e-13 as=1.02e-13 pd=1.28e-06 ps=1.28e-06 m=1
XP2 net4 net3 iovdd iovdd sg13_hv_pmos w=300.0n l=450.00n ng=1 ad=0.0 as=0.0 pd=0.0 ps=0.0 m=1
.ends
* End of subcircuit definition.

* Library name: sg13cmos5l_io
* Cell name: sg13cmos5l_GateLevelUpInv
* View name: schematic
.subckt sg13cmos5l_GateLevelUpInv ngate pgate iovdd core vdd vss
XI1 pgate core iovdd vdd vss sg13cmos5l_LevelUpInv
XI0 ngate core iovdd vdd vss sg13cmos5l_LevelUpInv
.ends
* End of subcircuit definition.

* Library name: sg13cmos5l_io
* Cell name: sg13cmos5l_IOPadOut4mA
* View name: schematic
.subckt sg13cmos5l_IOPadOut4mA pad c2p vdd vss iovdd iovss
XI2 net2 net1 iovdd c2p vdd vss sg13cmos5l_GateLevelUpInv
XI0 net1 iovdd iovss pad sg13cmos5l_Clamp_P2N2D
XI3 net2 iovss pad sg13cmos5l_Clamp_N2N2D
XI4 iovss pad pad iovdd sg13cmos5l_DCNDiode
XI1 pad pad iovdd iovss sg13cmos5l_DCPDiode
.ends
* End of subcircuit definition.

* Library name: sg13cmos5l_io
* Cell name: sg13cmos5l_IOPadOut30mA
* View name: schematic
.subckt sg13cmos5l_IOPadOut30mA pad c2p vdd vss iovdd iovss
XI2 net2 net1 iovdd c2p vdd vss sg13cmos5l_GateLevelUpInv
XI1 net1 iovdd iovss pad sg13cmos5l_Clamp_P15N15D
XI3 net2 iovss pad sg13cmos5l_Clamp_N15N15D
XI4 iovss pad pad iovdd sg13cmos5l_DCNDiode
XI0 pad pad iovdd iovss sg13cmos5l_DCPDiode
.ends
* End of subcircuit definition.

* Library name: sg13cmos5l_io
* Cell name: sg13cmos5l_IOPadIn
* View name: schematic
.subckt sg13cmos5l_IOPadIn pad p2c vdd vss iovdd iovss
XI0 p2c pad iovdd iovss vdd sg13cmos5l_LevelDown
XI2 iovss pad pad iovdd sg13cmos5l_DCNDiode
XI1 pad pad iovdd iovss sg13cmos5l_DCPDiode
.ends
* End of subcircuit definition.

* Library name: sg13cmos5l_io
* Cell name: sg13cmos5l_Clamp_P8N8D
* View name: schematic
.subckt sg13cmos5l_Clamp_P8N8D gate iovdd iovss pad
XP2 pad gate iovdd iovdd sg13_hv_pmos w=53.28u l=600.0n ng=8 ad=1.012e-11 as=1.212e-11 pd=5.632e-05 ps=7.024e-05 m=1
XP0 pad gate iovdd iovdd sg13_hv_pmos w=53.28u l=600.0n ng=8 ad=1.012e-11 as=1.212e-11 pd=5.632e-05 ps=7.024e-05 m=1
XD0 gate iovdd dpantenna l=480n w=480n m=1
.ends
* End of subcircuit definition.

* Library name: sg13cmos5l_io
* Cell name: sg13cmos5l_Clamp_N8N8D
* View name: schematic
.subckt sg13cmos5l_Clamp_N8N8D gate iovss pad
XN0 pad gate iovss iovss sg13_hv_nmos w=35.2u l=600.0n ng=8 ad=6.688e-12 as=8.008e-12 pd=3.824e-05 ps=4.764e-05 m=1
XD0 iovss gate dantenna l=780.00n w=780.00n m=1
.ends
* End of subcircuit definition.

* Library name: sg13cmos5l_io
* Cell name: sg13cmos5l_IOPadInOut16mA
* View name: schematic
.subckt sg13cmos5l_IOPadInOut16mA pad c2p p2c c2p_en vdd vss iovdd iovss
XI1 pad pad iovdd iovss sg13cmos5l_DCPDiode
XI2 net2 net1 c2p c2p_en iovdd vdd vss sg13cmos5l_GateDecode
XI5 iovss pad pad iovdd sg13cmos5l_DCNDiode
XI0 net1 iovdd iovss pad sg13cmos5l_Clamp_P8N8D
XI4 p2c pad iovdd iovss vdd sg13cmos5l_LevelDown
XI3 net2 iovss pad sg13cmos5l_Clamp_N8N8D
.ends
* End of subcircuit definition.

* Library name: sg13cmos5l_io
* Cell name: sg13cmos5l_IOPadOut16mA
* View name: schematic
.subckt sg13cmos5l_IOPadOut16mA pad c2p vdd vss iovdd iovss
XI2 net2 net1 iovdd c2p vdd vss sg13cmos5l_GateLevelUpInv
XI0 net1 iovdd iovss pad sg13cmos5l_Clamp_P8N8D
XI4 iovss pad pad iovdd sg13cmos5l_DCNDiode
XI3 net2 iovss pad sg13cmos5l_Clamp_N8N8D
XI1 pad pad iovdd iovss sg13cmos5l_DCPDiode
.ends
* End of subcircuit definition.

* Library name: sg13cmos5l_io
* Cell name: sg13cmos5l_IOPadTriOut4mA
* View name: schematic
.subckt sg13cmos5l_IOPadTriOut4mA pad c2p c2p_en vdd vss iovdd iovss
XI2 net2 net1 c2p c2p_en iovdd vdd vss sg13cmos5l_GateDecode
XI4 iovss pad pad iovdd sg13cmos5l_DCNDiode
XI3 net2 iovss pad sg13cmos5l_Clamp_N2N2D
XI0 net1 iovdd iovss pad sg13cmos5l_Clamp_P2N2D
XI1 pad pad iovdd iovss sg13cmos5l_DCPDiode
.ends
* End of subcircuit definition.

* Library name: sg13cmos5l_io
* Cell name: sg13cmos5l_IOPadTriOut16mA
* View name: schematic
.subckt sg13cmos5l_IOPadTriOut16mA pad c2p c2p_en vdd vss iovdd iovss
XI2 net2 net1 c2p c2p_en iovdd vdd vss sg13cmos5l_GateDecode
XI0 net1 iovdd iovss pad sg13cmos5l_Clamp_P8N8D
XI3 net2 iovss pad sg13cmos5l_Clamp_N8N8D
XI4 iovss pad pad iovdd sg13cmos5l_DCNDiode
XI1 pad pad iovdd iovss sg13cmos5l_DCPDiode
.ends
* End of subcircuit definition.

* Library name: sg13cmos5l_io
* Cell name: sg13cmos5l_IOPadTriOut30mA
* View name: schematic
.subckt sg13cmos5l_IOPadTriOut30mA pad c2p c2p_en vdd vss iovdd iovss
XI2 net2 net1 c2p c2p_en iovdd vdd vss sg13cmos5l_GateDecode
XI4 iovss pad pad iovdd sg13cmos5l_DCNDiode
XI3 net2 iovss pad sg13cmos5l_Clamp_N15N15D
XI0 net1 iovdd iovss pad sg13cmos5l_Clamp_P15N15D
XI1 pad pad iovdd iovss sg13cmos5l_DCPDiode
.ends
* End of subcircuit definition.

* Library name: sg13cmos5l_io
* Cell name: sg13cmos5l_Corner
* View name: schematic
.subckt sg13cmos5l_Corner vdd vss iovdd iovss
.ends
* End of subcircuit definition.

* Library name: sg13cmos5l_io
* Cell name: sg13cmos5l_Filler4000
* View name: schematic
.subckt sg13cmos5l_Filler4000 vdd vss iovdd iovss
.ends
* End of subcircuit definition.

* Library name: sg13cmos5l_io
* Cell name: sg13cmos5l_Filler1000
* View name: schematic
.subckt sg13cmos5l_Filler1000 vdd vss iovdd iovss
.ends
* End of subcircuit definition.

* Library name: sg13cmos5l_io
* Cell name: sg13cmos5l_Filler200
* View name: schematic
.subckt sg13cmos5l_Filler200 vdd vss iovdd iovss
.ends
* End of subcircuit definition.

* Library name: sg13cmos5l_io
* Cell name: sg13cmos5l_Filler400
* View name: schematic
.subckt sg13cmos5l_Filler400 vdd vss iovdd iovss
.ends
* End of subcircuit definition.

* Library name: sg13cmos5l_io
* Cell name: sg13cmos5l_Filler10000
* View name: schematic
.subckt sg13cmos5l_Filler10000 vdd vss iovdd iovss
.ends sg13cmos5l_Filler10000
* End of subcircuit definition.

* Library name: sg13cmos5l_io
* Cell name: sg13cmos5l_Clamp_P20N0D
* View name: schematic
.subckt sg13cmos5l_Clamp_P20N0D iovdd iovss pad
XP1 pad net2 iovdd iovdd sg13_hv_pmos w=133.2u l=600.0n ng=20 ad=2.531e-11 as=2.731e-11 pd=0.0001408 ps=0.0001547 m=1
XP0 pad net2 iovdd iovdd sg13_hv_pmos w=133.2u l=600.0n ng=20 ad=2.531e-11 as=2.731e-11 pd=0.0001408 ps=0.0001547 m=1
XR0 net2 iovdd iovdd rppd l=12.9u w=500n
.ends
* End of subcircuit definition.

* Library name: sg13cmos5l_io
* Cell name: sg13cmos5l_Clamp_N20N0D
* View name: schematic
.subckt sg13cmos5l_Clamp_N20N0D iovss pad
XN0 pad net2 iovss iovss sg13_hv_nmos w=88.000u l=600.0n ng=20 ad=1.672e-11 as=1.804e-11 pd=9.56e-05 ps=0.000105 m=1
XR0 iovss net2 iovss rppd l=3.54u w=500n
.ends
* End of subcircuit definition.

* Library name: sg13cmos5l_io
* Cell name: sg13cmos5l_IOPadAnalog
* View name: schematic
.subckt sg13cmos5l_IOPadAnalog pad padres vdd vss iovdd iovss
XI0 iovdd iovss pad sg13cmos5l_Clamp_P20N0D
XI5 iovss pad pad iovdd sg13cmos5l_DCNDiode
XI2 pad pad iovdd iovss sg13cmos5l_DCPDiode
XI3 padres iovss pad iovdd sg13cmos5l_SecondaryProtection
XI4 iovss pad sg13cmos5l_Clamp_N20N0D
.ends
* End of subcircuit definition.
